* Round 4: servo rail as built (pcb/rabbit-body-c/rabbit-body-c.kicad_pcb = gen/design.py): LM61495 U6 -> L6 -> 5 x 22 uF
* -> R2 5 mOhm -> SERVO_RAW -> TPS259470L U83 (steering, R831 549 R, C834 22 nF, C833 4.7 nF) and TPS259470L U88 (arm,
* R881 750 R, C884 22 nF, C883 4.7 nF), shared OVLO divider R166 61.9k / R167 10k.
* Model sources:
*   LM61495: datasheet/TI/lm61495.pdf (SNVSBZ4A) p.7 VFB 0.99-1.01 V, I_LS-LIMIT_10 9.8/11.5/12.9 A, I_SC_10 14/17.3/20 A;
*     p.25 current limit = average of IL-HS and IL-LS (hysteretic), ~IL-LS at low VIN; p.25-26 hiccup below 0.4 x VSET for
*     128 cycles, t_W 40 ms (p.8); t_SS 2.2 ms (p.8). Averaged current-mode model (no switching ripple), as round 1 servo.cir.
*   TPS259470L: datasheet/TI/tps25947.pdf (SLVSFC9C) p.9 R_ON 28 mOhm (45 max), I_LIM rows 549 R 5.40/6.07/6.60 A and
*     750 R 3.96/4.45/4.84 A, OVLO 1.183/1.20/1.223 V rising, 1.076/1.09/1.116 V falling; p.10 I_SC = 2.01 x I_LIM,
*     ITIMER: V_INT 2.57 V through 15 kOhm, I 1.2/1.8/2.5 uA, dV 1.286/1.51/1.741 V; p.31-34 blanking (no limit below
*     2 x I_LIM until ITIMER expires), active limit after expiry, fast trip -> restart current limited (the 30 us off time
*     is not modelled), true reverse current blocking (p.35). Thermal shutdown is not modelled: the runner reports the
*     current-limit dissipation against fig. 6-37 p.18.
*   Capacitors: Samsung CL31A226KAHNNNE 22 uF 25 V X5R 1206 taken at 50 % of nominal at 6-7.4 V (DC bias, assumed);
*     Panasonic EEHZK1E471P 470 uF 25 V hybrid polymer ESR 20 mOhm; EEH-ZK1V221UP 220 uF ESR 27 mOhm [catalogue values
*     from memory]. Schottkys from models.lib (B340A, B540C).
.include models.lib

.param L6=3.3u C610=22u C889=10u C885=22u C886=22u C887=220u C835=470u C836=470u
.param R831=549 C834=22n R881=750 C884=22n R166=61.9k R167=10k R2=5m
.param vin=16.8 vset0=6.0 vset1=7.4 t_sel=1 kp=15 ki=4.1e5 kc=5 k22=0.5 k10=0.6 ineg=0
.param ilim_b=14.4 hic_on=1
.param st_ilim={3334/R831} arm_ilim={3334/R881} st_k=1 arm_k=1 ron=28m
.param i_itm=1.8u dv_itm=1.51 vint=2.57
.param ovr=1.20 ovf=1.09 st_en_t=-1 arm_en_t=-1 arm_off_t=10
.param i_arm0=0.3 i_steer=1.0 i_stall=12 t_stall=5m t_stall_len=1 i_steer2=1m t_steer2=1
.param vset_ic=6.0

Vone one 0 1
Vin VBUS 0 {vin}
Rf4 VBUS STEER_IN 12m
Cin STEER_IN 0 12u

* averaged LM61495: input current = duty x IL, switch-node average, PI voltage loop, average current limit ilim_b
Vsel sel 0 PWL(0 0 {t_sel} 0 {t_sel+10u} 1)
Bvset vsetn 0 V = {vset0}+({vset1}-{vset0})*V(sel)
Bin STEER_IN 0 I = V(hon)*V(swa)*I(VL)/max(V(STEER_IN),1)
Bsw swa 0 V = V(hon)*max(0, min(V(STEER_IN), V(SERVO_BUCK)+{kc}*(V(icmd)-I(VL))))
VL swa swl 0
L6 swl SERVO_BUCK {L6} IC=0
Berr err 0 V = V(vsetn)-V(SERVO_BUCK)
Bint 0 integ I = V(hon)*{ki}*V(err)*(1-u(V(integ)-{ilim_b})*u(V(err)))*(1-u(-{ineg}-V(integ))*u(-V(err)))
+ - (1-V(hon))*V(integ)*1e4
Cint integ 0 1
Bic icmd 0 V = max(-{ineg}, min({ilim_b}, {kp}*V(err)+V(integ)))
* auto (PFM) mode cannot sink: icmd is clamped at >= 0 (ineg = 0)
Cout SERVO_BUCK cesr {5*C610*k22}
Resr cesr 0 1m
C607 SERVO_BUCK 0 100n
* hiccup: below 0.4 x VSET for > 0.3 ms (128 cycles at 414 kHz) -> off for t_W 40 ms (enabled after t_SS2)
Blow low 0 V = {hic_on}*u(time-3m)*u(0.4*V(vsetn)-V(SERVO_BUCK))*V(hon)
Rlow low lowf 1k
Clow lowf 0 0.31u
Shic one hict lowf 0 SWH
.model SWH SW(VT=0.63 VH=0.01 RON=1 ROFF=1e13)
Rhict hict 0 1Meg
Chict hict 0 40n
Bhoff hoffd 0 V = 1-u(V(hict)-0.368)
Shon one hon hoffd 0 SWL
Rhon hon 0 1Meg
Chon hon 0 1p
* hiccup timer: hict is pulled to 1 V while low persists, then decays to 1/e in t_W = 40 ms (1Meg x 40n)
.model SWL SW(VT=0.5 VH=0.05 RON=1 ROFF=1e13)

R2 SERVO_BUCK SERVO_RAW {R2}
C889 SERVO_RAW c889e {C889*k10}
R889e c889e 0 3m
C831 SERVO_RAW 0 100n
C881 SERVO_RAW 0 100n

* shared OVLO divider R166 / R167
R166 SERVO_RAW OVLO_SERVO {R166}
R167 OVLO_SERVO 0 {R167}
Sovl one sov OVLO_SERVO 0 SWOVL
.model SWOVL SW(VT={(ovr+ovf)/2} VH={(ovr-ovf)/2} RON=1 ROFF=1e13)
Rsov sov 0 1Meg
Csov sov 0 1p

.subckt EF in out sov ilim=1 ron=28m citm=22n itm=1.8u dvt=1.51 vint=2.57 en_t=-1 off_t=10
* TPS259470L (SLVSFC9C p.31-35): limit flag lim (latched by fast trip or ITIMER expiry, released when the demand falls
* below I_LIM), ITIMER discharge only while I > I_LIM and not limiting, RCB (no reverse current)
Vonee onee 0 1
Ben en 0 V = u(time-{en_t})*(1-u(time-{off_t}))
Bdem dem 0 V = V(en)*(1-V(sov))*max(0,(V(in)-V(out))/{ron})
Bi in out I = V(en)*(1-V(sov))*min(max(0,(V(in)-V(out))/{ron}), {ilim}*(2.01-1.01*V(lim)))
Saov onee aov dem 0 SWOV1
.model SWOV1 SW(VT={ilim} VH={0.01*ilim} RON=1 ROFF=1e13)
Raov aov 0 1Meg
Caov aov 0 1p
Saft onee aft dem 0 SWFT
.model SWFT SW(VT={2.01*ilim} VH={0.01*ilim} RON=1 ROFF=1e13)
Raft aft 0 1Meg
Caft aft 0 1p
Citm itm 0 {citm}
Bitm itm 0 I = V(aov)*(1-V(lim))*{itm} - (1-V(aov)*(1-V(lim)))*({vint}-V(itm))/15k
Bnitm nitm 0 V = -V(itm)
Sexp onee exp nitm 0 SWEXP
.model SWEXP SW(VT={-(vint-dvt)} VH=5m RON=1 ROFF=1e13)
Rexp exp 0 1Meg
Cexp exp 0 1p
* SR latch: set by fast trip or expiry, held while the demand stays >= 0.98 I_LIM
Bset lset 0 V = max(max(V(aft), V(exp)), V(lim)*0.5*(1+tanh((V(dem)-0.98*{ilim})/(0.005*{ilim}))))
Slim onee lim lset 0 SWLAT
.model SWLAT SW(VT=0.5 VH=0.05 RON=1 ROFF=1e13)
Rlim lim 0 1Meg
Clim lim 0 1p
.ends

XU83 SERVO_RAW st_o sov EF ilim={st_ilim*st_k} ron={ron} citm={C834} itm={i_itm} dvt={dv_itm} vint={vint} en_t={st_en_t}
XU88 SERVO_RAW arm_o sov EF ilim={arm_ilim*arm_k} ron={ron} citm={C884} itm={i_itm} dvt={dv_itm} vint={vint} en_t={arm_en_t} off_t={arm_off_t}

* steering side: 2 x 470 uF polymer + 1 uF + B540C, steering servos as a resistive hold load + an optional step
Vst_m st_o SERVO_PWR 0
C835 SERVO_PWR c835e {C835}
R835e c835e 0 20m
C836 SERVO_PWR c836e {C836}
R836e c836e 0 20m
C832 SERVO_PWR 0 1u
D831 0 SERVO_PWR B540C
Rsteer SERVO_PWR 0 {vset1/i_steer}
Vst2 st2c 0 PWL(0 0 {t_steer2} 0 {t_steer2+1u} 1)
Sst2 SERVO_PWR st2r st2c 0 SWLD
Rst2 st2r 0 {vset1/i_steer2}

* arm side: 220 uF polymer + 2 x 22 uF + 2 x 1 uF + B340A, cable 0.5 uH / 30 mOhm, idle load, switched stall resistor
Varm_m arm_o ARM_PWR 0
C887 ARM_PWR c887e {C887}
R887e c887e 0 27m
Carm ARM_PWR carme {(C885+C886)*k22}
Rcarme carme 0 2m
C882 ARM_PWR 0 2u
D88 0 ARM_PWR B340A
Rarm_idle ARM_PWR 0 {vset1/i_arm0}
R890 ARM_PWR 0 4.7k
Lcab ARM_PWR cab 0.5u
Rcab cab cab2 30m
Vstc stc 0 PWL(0 0 {t_stall} 0 {t_stall+1u} 1 {t_stall+t_stall_len} 1 {t_stall+t_stall_len+1u} 0)
Sstall cab2 stl stc 0 SWLD
.model SWLD SW(VT=0.5 VH=0.01 RON=1m ROFF=1e13)
Rstall stl 0 {vset1/i_stall}

.ic V(SERVO_BUCK)={vset_ic} V(SERVO_RAW)={vset_ic} V(ARM_PWR)={vset_ic} V(SERVO_PWR)={vset_ic} V(cesr)={vset_ic}
+ V(c889e)={vset_ic} V(carme)={vset_ic} V(c887e)={vset_ic} V(c835e)={vset_ic} V(c836e)={vset_ic}
+ V(STEER_IN)={vin} V(hon)=1 V(XU83.itm)={vint} V(XU88.itm)={vint} V(integ)=1.5
.end
